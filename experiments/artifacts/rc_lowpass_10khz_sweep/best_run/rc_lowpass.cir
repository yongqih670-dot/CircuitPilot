* CircuitPilot RC low-pass filter
Vin in 0 AC 1
R1 in out 1600
C1 out 0 1e-08
.control
set wr_singlescale
set wr_vecnames
ac dec 100 15.9154943092 15915494.3092
wrdata ac_results.dat vdb(out) vp(out)
quit
.endc
.end

* CircuitPilot RC low-pass filter
Vin in 0 AC 1
R1 in out 1000
C1 out 0 1.59154943e-07
.control
set wr_singlescale
set wr_vecnames
ac dec 100 10 1000000
wrdata ac_results.dat vdb(out) vp(out)
quit
.endc
.end

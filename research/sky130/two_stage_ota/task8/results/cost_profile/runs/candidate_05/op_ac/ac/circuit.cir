* CircuitPilot Research Task 7 real SKY130 two-stage Miller OTA
.option scale=1u
.param mc_mm_switch=0 mc_pr_switch=0
.include "C:/Users/Eterna1/AppData/Local/Temp/circuitpilot-sky130-model-cache/d88fa42b4f42f7b1f698/invariant.spice"
.include "C:/Users/Eterna1/AppData/Local/Temp/circuitpilot-sky130-model-cache/d88fa42b4f42f7b1f698/sky130_fd_pr__nfet_01v8__tt.corner.spice"
.include "C:/Users/Eterna1/AppData/Local/Temp/circuitpilot-sky130-model-cache/d88fa42b4f42f7b1f698/sky130_fd_pr__pfet_01v8__tt.corner.spice"
.temp 27
VDD vdd 0 DC 1.8
VTAIL tail_bias 0 DC 0.72
VINP vin_plus 0 DC 0.9 AC 0.5 0
VINN vin_minus 0 DC 0.9 AC 0.5 180
VLOADBIAS second_load_bias 0 DC 0.469110098544
XM1 mirror vin_minus tail 0 sky130_fd_pr__nfet_01v8 W=1.13433631929 L=0.857747525505
XM2 stage1_out vin_plus tail 0 sky130_fd_pr__nfet_01v8 W=1.13433631929 L=0.857747525505
XM3 mirror mirror vdd vdd sky130_fd_pr__pfet_01v8 W=17.5734746607 L=0.401337915143
XM4 stage1_out mirror vdd vdd sky130_fd_pr__pfet_01v8 W=17.5734746607 L=0.401337915143
XM5 tail tail_bias 0 0 sky130_fd_pr__nfet_01v8 W=17.7067490827 L=0.211496436545
XM6 vout stage1_out 0 0 sky130_fd_pr__nfet_01v8 W=3.52693358263 L=0.30779344024
XM7 vout second_load_bias vdd vdd sky130_fd_pr__pfet_01v8 W=5.74315863481 L=0.986140483802
CC stage1_out vout 6.35349374161e-14
CL vout 0 1e-12
.control
set wr_singlescale
set wr_vecnames
ac dec 30 10 10000000000
wrdata C:/Users/Eterna1/AppData/Local/Temp/circuitpilot-sky130-8w9gf_dj/ac.dat vdb(vout) 180/pi*vp(vout)
quit
.endc
.end

* CircuitPilot Task 9 PVT capability probe
.option scale=1u
.param mc_mm_switch=0 mc_pr_switch=0
.include "invariant.spice"
.include "sky130_fd_pr__nfet_01v8__ss.corner.spice"
.include "sky130_fd_pr__pfet_01v8__ss.corner.spice"
.temp 27
VDD vdd 0 DC 1.8
VGN gn 0 DC 0.9
VGP gp 0 DC 0.9
XMN vdd gn 0 0 sky130_fd_pr__nfet_01v8 W=1 L=0.15
XMP 0 gp vdd vdd sky130_fd_pr__pfet_01v8 W=1 L=0.15
.control
set wr_singlescale
set wr_vecnames
op
wrdata probe.dat v(vdd) i(VDD) @m.xmn.msky130_fd_pr__nfet_01v8[vth] @m.xmn.msky130_fd_pr__nfet_01v8[gm] @m.xmp.msky130_fd_pr__pfet_01v8[vth] @m.xmp.msky130_fd_pr__pfet_01v8[gm]
quit
.endc
.end

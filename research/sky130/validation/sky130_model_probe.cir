* CircuitPilot SKY130 environment validation probe (not benchmark data)
.option scale=1u
.param mc_mm_switch=0 mc_pr_switch=0
.include "P:/libs.tech/ngspice/parameters/invariant.spice"
.include "P:/libs.ref/sky130_fd_pr/spice/sky130_fd_pr__nfet_01v8__tt.corner.spice"
.temp 27
VDD vdd 0 DC 1.8
VIN in 0 DC 0.9 AC 1
RD vdd out 10000
X1 out in 0 0 sky130_fd_pr__nfet_01v8 W=1.26 L=0.15
CL out 0 1e-12
.control
set wr_singlescale
set wr_vecnames
op
wrdata R:/sky130_probe_dc.dat v(vdd) v(in) v(out) i(vdd)
wrdata R:/sky130_probe_device.dat @m.x1.msky130_fd_pr__nfet_01v8[vgs] @m.x1.msky130_fd_pr__nfet_01v8[vds] @m.x1.msky130_fd_pr__nfet_01v8[gm] @m.x1.msky130_fd_pr__nfet_01v8[gds] @m.x1.msky130_fd_pr__nfet_01v8[vth] @m.x1.msky130_fd_pr__nfet_01v8[vdsat]
ac dec 20 10 1e9
wrdata R:/sky130_probe_ac.dat vdb(out) vp(out)
quit
.endc
.end
